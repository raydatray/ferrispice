Diode at 100 V, solved by source stepping
Vin n1 0 DC 100
D1 n1 n2
R n2 0 50
.dc
.end
